* D:\Descargas\Santana, Jesus TEC200 1347 Practica 04\Santana, Jesus TEC200 1347 Practica 04 FA.sch

* Schematics Version 9.1 - Web Update 1
* Wed Oct 22 23:11:46 2025

** Analysis setup **
.tran 0ns 2560ns
.OP

* From [PSPICE NETLIST] section of pspiceev.ini:
.lib "nom.lib"

.INC "Santana, Jesus TEC200 1347 Practica 04 FA.net"
.INC "Santana, Jesus TEC200 1347 Practica 04 FA.als"

.probe

.END
